* Atom Lithography Machine - Laser AOM RF VCA (Log-Linearized AD8367), Reverse-Biased 2-Color Pyrometer TIA & Crowbar
* BOM: S5.5-03, S5.5-01, S5.5-04, S5.3-03
* Epistemic status: M0/M1 DESIGN_ONLY; no_lab_measurement=true; no_physical_fab=true.

.temp 26.85
.options reltol=1e-4 vntol=1e-6 abstol=1e-12

* --- Semiconductor & Op-Amp Models ---
.model D_PD_MOD  D(IS=1e-11 N=1.2 RS=5 CJO=1p BV=25)
.model M_SQJ461  PMOS(LEVEL=1 VTO=-2.5 KP=4.0 RD=0.04 RS=0.02)
.model M_2N7002  NMOS(LEVEL=1 VTO=1.8 KP=0.35 RD=1.5 RS=0.5)
.model D_Z12V    D(IS=1e-12 BV=12.0 IBV=5m N=1.2 RS=2.0)

* --- Wideband FET-Input TIA Op-Amp (OPA657: A0=1e5, GBP=1.6 GHz, Cin=4.5 pF, en=4.8 nV/rtHz) ---
.subckt OPAMP_OPA657 inp inn out
Cin inp inn 4.5p
Rin inp inn 1T noisy=0
Rnw nw 0 1390.6 temp=26.85
Evn inp_i inp nw 0 1.0
Egain n1 0 inp_i inn 1e5
Rp n1 n2 1k noisy=0
Cp n2 0 9.9472n
Ebuf n_out 0 n2 0 1.0
Rout n_out out 5 noisy=0
.ends OPAMP_OPA657

* --- Precision JFET Integrator Op-Amp (OPA140: A0=1e6, GBP=11 MHz, low Ib=10 pA) ---
.subckt OPAMP_OPA140 inp inn out
Cin inp inn 5.0p
Rin inp inn 1T noisy=0
Ibias inn 0 DC 10p
Egain n1 0 inp inn 1e6
Rp n1 n2 1k noisy=0
Cp n2 0 14.4686u
Ebuf n_out 0 n2 0 1.0
Rout n_out out 10 noisy=0
.ends OPAMP_OPA140

* --- Analog Switch Model (ADG1211: Ron=120 Ohm, Roff=10 GOhm) ---
.model SW_ADG1211 SW(VT=1.65 VH=0.1 RON=120 ROFF=10G)
.model SW_MOS_CB  SW(VT=1.65 VH=0.1 RON=1.5 ROFF=100Meg)

* Supplies
Vn5a vn5a 0 DC -5.0
Vp5rf vp5rf 0 DC 5.0
Vp3v3 vp3v3 0 DC 3.3
V24_dio v24_d 0 DC 24.0

* =========================================================================
* 1) REVERSE-BIASED 2-COLOR PYROMETER TIAs (POSITIVE 0..+2.5V OUTPUT!) + TLV3501 1687K OTEMP
* =========================================================================
* Channel 1: InGaAs 1550 nm (Anode -> -5V via 1k, Cathode -> ig_sum virtual GND => +5V REVERSE BIAS!)
Rpb_ig vn5a pd_an_ig 1.0k
Cpb_ig pd_an_ig 0 100n
Dpd_ig pd_an_ig ig_sum D_PD_MOD
* Photocurrent flows Cathode (ig_sum) -> Anode (pd_an_ig) => POSITIVE TIA output (+1.000 V for 10 uA!)
Ipd_ig ig_sum pd_an_ig DC 0 AC 1 PULSE(0 10u 5u 20n 20n 80u 200u)
Cpd_ig ig_sum 0 11.5p
X_ig   0 ig_sum ig_out OPAMP_OPA657
Rf_ig  ig_out ig_sum 100k
Cf_ig  ig_out ig_sum 12p
Rld_ig ig_out 0 10k

* Channel 2: Si 850 nm (Anode -> -5V via 1k, Cathode -> si_sum => +5V REVERSE BIAS, POSITIVE +1.000 V!)
* Steps 0 -> 5 uA (+1.00 V healthy) at 5 us, then to 9 uA (+1.80 V > +1.50 V 1687K Si melt!) at 120 us!
Rpb_si vn5a pd_an_si 1.0k
Cpb_si pd_an_si 0 100n
Dpd_si pd_an_si si_sum D_PD_MOD
Ipd_si si_sum pd_an_si DC 0 AC 1 PWL(0 0 5u 0 5.02u 5u 119.9u 5u 120u 9u 220u 9u)
Cpd_si si_sum 0 2.5p
X_si   0 si_sum si_out OPAMP_OPA657
Rf_si  si_out si_sum 200k
Cf_si  si_out si_sum 6.0p
Rld_si si_out 0 10k

* Real TLV3501AID 1687 K Hardware Over-Temperature Comparator (VREF=+1.50 V on IN+, si_out on IN-, SHDN=0V)
Vot_thr otemp_thr 0 DC 1.50
Botemp  otemp_ok 0 V = 1.65 * (1.0 + tanh(200.0 * (V(otemp_thr) - V(si_out))))

* =========================================================================
* 2) REVERSE-BIASED 1.0 ms PULSE-ENERGY INTEGRATOR (POSITIVE +1.0 V / +2.0 V, <1% LINEARITY)
* =========================================================================
Vint_rst int_rst 0 DC 3.3 PWL(0 3.3 49u 3.3 50u 0 1.299m 0 1.300m 3.3)
Rpb_e1   vn5a pd_an_e1 1.0k
Dpd_e1   pd_an_e1 int1_sum D_PD_MOD
Ieng_1x  int1_sum pd_an_e1 DC 0 PULSE(0 100u 0.100m 1u 1u 0.999m 5m)
Cint_1x  int1_out int1_sum 100n
Rlk_1x   int1_out int1_sum 10G
Srst_1x  int1_out int1_sum int_rst 0 SW_ADG1211
Xint_1x  0 int1_sum int1_out OPAMP_OPA140
Rld_1x   int1_out 0 100k

Rpb_e2   vn5a pd_an_e2 1.0k
Dpd_e2   pd_an_e2 int2_sum D_PD_MOD
Ieng_2x  int2_sum pd_an_e2 DC 0 PULSE(0 200u 0.100m 1u 1u 0.999m 5m)
Cint_2x  int2_out int2_sum 100n
Rlk_2x   int2_out int2_sum 10G
Srst_2x  int2_out int2_sum int_rst 0 SW_ADG1211
Xint_2x  0 int2_sum int2_out OPAMP_OPA140
Rld_2x   int2_out 0 100k

* =========================================================================
* 3) 80-200 MHz AOM RF CHAIN WITH +5V BIAS TEE + 100 nF DC-BLOCKING CAP (0 V DC ON SMA!)
* =========================================================================
Vrf_lo   rf_src 0 DC 0 AC 1
Rrf_src  rf_src rf_in 50
Crf_ac1  rf_in  rf_mid 100n
Rrf_dc   rf_mid 0 100k
Crf_par  rf_mid 0 1.5p
Crf_ac2  rf_mid rf_drv 100n
* +5 V ADL5602 bias choke fed on rf_drv, ISOLATED from 50 Ohm coax by C_RF_DCBLK (100 nF)!
Lrf_chk  vp5rf  rf_drv 1.0u
Crf_dblk rf_drv rf_out 100n
Rrf_ld   rf_out 0 50

* =========================================================================
* 4) LOG-LINEARIZED 50 dB/V AD8367 VCA + < 50 us REAL HIGH-SIDE PMOS 24 V CROWBAR
* =========================================================================
* PID linear gain command u_cmd in [0.65, 1.40] mapped via log-linearized LUT into AD8367 Vctrl in [0.425, 0.559] V:
*   V_ctrl = 0.50 + 0.40 * log10(u_cmd) => G_ad8367 = 10^(2.5 * (V_ctrl - 0.50)) == u_cmd (EXACT linear gain!)
Vu_cmd   u_cmd 0 DC 0.65 PWL(0 0.65 49u 0.65 50u 1.40 300u 1.40)
Blut_vca vca_lut 0 V = 0.50 + 0.40 * log10(max(V(u_cmd), 0.05))
Rvca_s   vca_lut vca_ctrl 499
Cvca_f   vca_ctrl 0 2.2n
Vilk_a   ilk_ok 0 DC 3.3 PWL(0 3.3 150u 3.3 150.5u 0 300u 0)
Bcb_drv  cb_trip 0 V = 3.3 - V(ilk_ok)
Scb_vca  vca_ctrl 0 cb_trip 0 SW_MOS_CB
* True AD8367 50 dB/V exponential gain response (drops to 0 when clamped by crowbar!)
Bad8367  vca_gain_lin 0 V = (V(vca_ctrl) > 0.05) ? pow(10.0, 2.5 * (V(vca_ctrl) - 0.50)) : 0.0

* Real High-Side Series SQJ461EP P-MOSFETs + Low-Side 2N7002K Drivers + 12V Zener Clamps (OBS-037 FIX!)
M_gdrv_a gdrv_a ilk_ok 0 0 M_2N7002 W=2 L=1
R_pu_a   v24_d  pmos_ga 10k
R_div_a  pmos_ga gdrv_a 10k
Dz_a     pmos_ga v24_d  D_Z12V
M_dio_a  dio_mid pmos_ga v24_d v24_d M_SQJ461 W=10 L=1

M_gdrv_b gdrv_b ilk_ok 0 0 M_2N7002 W=2 L=1
R_pu_b   dio_mid pmos_gb 10k
R_div_b  pmos_gb gdrv_b  10k
Dz_b     pmos_gb dio_mid D_Z12V
M_dio_b  diode_en pmos_gb dio_mid dio_mid M_SQJ461 W=10 L=1

Rdio_pd  diode_en 0 1.0k
Cdio_cab diode_en 0 2.0n

* =========================================================================
* 5) CLOSED-LOOP +8% LASER SURGE TEST WITH LOG-LINEARIZED AD8367 (ZERO LIMIT CYCLE!)
* =========================================================================
* Plant: P_out = (1 + surge) * G_ad8367(V_lut(u_pid)) filtered by tau = 15 us thermal/AOM pole
* PI controller (kp=0.42, ki=36000 s^-1) holds P_out = 1.000 against +8% surge at t=50 us!
V_surge  surge_in 0 DC 1.00 PWL(0 1.00 49u 1.00 50u 1.08 220u 1.08)
B_err    pid_err  0 V = 1.00 - V(p_meas)
* Integrator: d(i_term)/dt = 36000 * pid_err -> R=27.78k, C=1nF, initialized at 1.00 V
G_int    0 pid_int pid_err 0 36u
C_int    pid_int 0 1n IC=1.00
R_int_lk pid_int 0 100Meg
B_upid   u_pid    0 V = min(max(V(pid_int) + 0.42 * V(pid_err), 0.65), 1.40)
* Log-linearized pre-distortion LUT -> AD8367 50 dB/V -> exact linear modulation!
B_lut_cl v_cl_lut 0 V = 0.50 + 0.40 * log10(V(u_pid))
B_p_raw  p_raw    0 V = V(surge_in) * pow(10.0, 2.5 * (V(v_cl_lut) - 0.50))
R_tau    p_raw    p_meas 15k
C_tau    p_meas   0      1n IC=1.00

.control
set noaskquit

* 0) DC Operating Point: Verify 0 V DC on SMA RF output (C_RF_DCBLK) & +5 V reverse bias on photodiodes
op
let rf_out_dc_v = abs(v(rf_out))
let pd_ig_rev_bias_v = v(ig_sum) - v(pd_an_ig)
let pd_si_rev_bias_v = v(si_sum) - v(pd_an_si)
print rf_out_dc_v pd_ig_rev_bias_v pd_si_rev_bias_v

* 1) AC Analysis: 2-Color TIA -3 dB bandwidth & 80-200 MHz AOM RF 50 Ohm flatness
ac dec 100 100 500Meg
meas ac z_dc_ingaas FIND vm(ig_out) AT=1k
meas ac z_dc_si     FIND vm(si_out) AT=1k
let ig_3db = 0.707107 * z_dc_ingaas
let si_3db = 0.707107 * z_dc_si
meas ac f3db_ingaas_hz WHEN vm(ig_out)=$&ig_3db FALL=1
meas ac f3db_si_hz     WHEN vm(si_out)=$&si_3db FALL=1
meas ac rf_gain_80m_db  FIND vdb(rf_out) AT=80Meg
meas ac rf_gain_200m_db FIND vdb(rf_out) AT=200Meg
let rf_flatness_db = abs(rf_gain_200m_db - rf_gain_80m_db)
print rf_flatness_db

* 2) Transient A: Fast POSITIVE 2-Color TIA Step + TLV3501 1687K Trip + Log-Linearized VCA + PMOS Crowbar + Surge
tran 20n 220u 0 50n uic
* InGaAs TIA (POSITIVE 0 -> +1.000 V!)
meas tran ig_v_final FIND v(ig_out) AT=40u
let ig_v10 = 0.10 * ig_v_final
let ig_v90 = 0.90 * ig_v_final
meas tran ig_t10 WHEN v(ig_out)=$&ig_v10 RISE=1
meas tran ig_t90 WHEN v(ig_out)=$&ig_v90 RISE=1
let tau_rise_ingaas_s = ig_t90 - ig_t10

* Si TIA (POSITIVE 0 -> +1.000 V at 40 us; +1.80 V > 1.50 V OTEMP trip at 160 us!)
meas tran si_v_final FIND v(si_out) AT=40u
let si_v10 = 0.10 * si_v_final
let si_v90 = 0.90 * si_v_final
meas tran si_t10 WHEN v(si_out)=$&si_v10 RISE=1
meas tran si_t90 WHEN v(si_out)=$&si_v90 RISE=1
let tau_rise_si_s = si_t90 - si_t10
meas tran otemp_ok_healthy_v FIND v(otemp_ok) AT=40u
meas tran otemp_ok_1687k_v   FIND v(otemp_ok) AT=160u
print tau_rise_ingaas_s tau_rise_si_s otemp_ok_healthy_v otemp_ok_1687k_v

* Log-linearized AD8367 VCA modulation ratio [0.65, 1.40] & Hardware Crowbar Cutoff (< 50 us!)
meas tran vca_gain_lo FIND v(vca_gain_lin) AT=30u
meas tran vca_gain_hi FIND v(vca_gain_lin) AT=120u
let vca_mod_ratio = vca_gain_hi / vca_gain_lo
print vca_mod_ratio

let vca_10 = 0.10 * vca_gain_hi
meas tran vca_cb_t10 WHEN v(vca_gain_lin)=$&vca_10 FALL=1 TD=149u
let crowbar_vca_cutoff_s = vca_cb_t10 - 150u

meas tran diode_v_on  FIND v(diode_en) AT=120u
meas tran diode_v_off FIND v(diode_en) AT=200u
let dio_10 = 0.10 * diode_v_on
meas tran dio_cb_t10 WHEN v(diode_en)=$&dio_10 FALL=1 TD=149u
let crowbar_diode_cutoff_s = dio_cb_t10 - 150u
print diode_v_on diode_v_off crowbar_vca_cutoff_s crowbar_diode_cutoff_s

* Closed-loop +8% surge tail stability (proves ZERO 16-24% limit-cycle oscillation!)
meas tran cl_p_tail_max MAX v(p_meas) FROM=160u TO=215u
meas tran cl_p_tail_min MIN v(p_meas) FROM=160u TO=215u
let cl_p_tail_pp = cl_p_tail_max - cl_p_tail_min
print cl_p_tail_max cl_p_tail_min cl_p_tail_pp

* 3) Transient B: 1.0 ms Pulse-Energy Integrator 2x Linearity Sweep (POSITIVE +1.0 V / +2.0 V) & Reset
tran 1u 1.6m 0 2u
meas tran v_int_1x FIND v(int1_out) AT=1.20m
meas tran v_int_2x FIND v(int2_out) AT=1.20m
meas tran v_int_1x_after_rst FIND v(int1_out) AT=1.55m
let int_ratio_2x = v_int_2x / v_int_1x
let int_lin_err_pct = abs(int_ratio_2x - 2.0) / 2.0 * 100.0
print v_int_1x v_int_2x int_ratio_2x int_lin_err_pct

quit 0
.endc
.end
