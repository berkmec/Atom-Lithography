* S9.4-02 Option-Q Realizable 7-Section Lumped Cryo NbTiN LC Impedance Transformer (50 Ohm <-> 3000 Ohm)
* OBS-105 closure: Replaces unrealizable Z0=1188.8/2409.7 Ohm quarter-wave T-lines (>6x free-space 377 Ohm)
* with physically realizable planar superconducting NbTiN spiral/meander inductors (0.98..52.8 nH, L_k ~ 20-50 pH/sq,
* I_c > 100 uA >> -100 dBm qRAM readout current) and cryogenic MIM/interdigital capacitors (7.8..274 fF) at 20 mK.
* Band: 4.0 - 8.0 GHz (f0 = 6.0 GHz), Superconducting NbTiN Q_int = 1e5 @ 20 mK MXC; 300 K bulkhead lane is pure 50 Ohm.
* Epistemic: DESIGN_ONLY, no_lab_measurement=true

.temp -273.13

* Port 1: 50 Ohm source with V_src = 2 V AC so incident wave a1 = 1/sqrt(50)
* Exact Kurokawa power-wave S-parameters between Z0=50 Ohm and ZL=3000 Ohm:
*   S11 = V(p1) - 1,  S21 = V(p2) * sqrt(50 / 3000)
VSRC src 0 DC 0 AC 2.0
RS   src p1 50.0

* 7-Section Lumped Cryogenic Superconducting NbTiN LC Matching Ladder (zero >200 Ohm T-lines!)
* Section 1: NbTiN planar spiral L=0.97511 nH + cryo MIM C=0.274358 pF (Q_int=1e5)
L1  p1 n1a 9.751100000e-10
RL1 n1a  n1 3.67607809e-04
C1  n1  0     2.743580000e-13
RC1 n1  0     9.66832527e+06
* Section 2: NbTiN planar spiral L=1.86565 nH + cryo MIM C=0.207407 pF (Q_int=1e5)
L2  n1 n2a 1.865650000e-09
RL2 n2a  n2 7.03333480e-04
C2  n2  0     2.074070000e-13
RC2 n2  0     1.27892616e+07
* Section 3: NbTiN planar spiral L=3.77273 nH + cryo MIM C=0.108430 pF (Q_int=1e5)
L3  n2 n3a 3.772730000e-09
RL3 n3a  n3 1.42228570e-03
C3  n3  0     1.084300000e-13
RC3 n3  0     2.44635468e+07
* Section 4: NbTiN planar spiral L=6.36368 nH + cryo MIM C=0.064422 pF (Q_int=1e5)
L4  n3 n4a 6.363680000e-09
RL4 n4a  n4 2.39905084e-03
C4  n4  0     6.442200000e-14
RC4 n4  0     4.11751014e+07
* Section 5: NbTiN planar spiral L=15.93653 nH + cryo MIM C=0.030152 pF (Q_int=1e5)
L5  n4 n5a 1.593653000e-08
RL5 n5a  n5 6.00793027e-03
C5  n5  0     3.015200000e-14
RC5 n5  0     8.79736795e+07
* Section 6: NbTiN planar spiral L=27.96562 nH + cryo MIM C=0.017408 pF (Q_int=1e5)
L6  n5 n6a 2.796562000e-08
RL6 n6a  n6 1.05427904e-02
C6  n6  0     1.740800000e-14
RC6 n6  0     1.52377205e+08
* Section 7: NbTiN planar spiral L=52.75950 nH + cryo MIM C=0.007776 pF (Q_int=1e5)
L7  n6 n7a 5.275950000e-08
RL7 n7a  p2 1.98898629e-02
C7  p2  0     7.776000000e-15
RC7 p2  0     3.41124278e+08

* Port 2: 3000 Ohm high-Z NbTiN M4 cavity-QED bus load (on-chip 20 mK MXC matching module)
RL p2 0 3000.0

.control
set noaskquit
ac lin 801 2.0e9 10.0e9
let s11_c = v(p1) - 1.0
let s21_c = v(p2) * sqrt(50.0 / 3000.0)
let s11_mag = mag(s11_c)
let s21_mag = mag(s21_c)
let s11_db = 20.0 * log10(s11_mag + 1e-12)
let s21_db = 20.0 * log10(s21_mag + 1e-12)
let passivity = s11_mag * s11_mag + s21_mag * s21_mag

meas ac s11_6ghz_db FIND s11_db AT=6.0e9
meas ac s21_6ghz_db FIND s21_db AT=6.0e9
meas ac s11_4ghz_db FIND s11_db AT=4.0e9
meas ac s11_8ghz_db FIND s11_db AT=8.0e9
meas ac max_s11_4_8_db MAX s11_db FROM=4.0e9 TO=8.0e9
meas ac min_s21_4_8_db MIN s21_db FROM=4.0e9 TO=8.0e9
meas ac max_passivity MAX passivity FROM=4.0e9 TO=8.0e9
meas ac bw20_lo_hz WHEN s11_db=-20.0 CROSS=1
meas ac bw20_hi_hz WHEN s11_db=-20.0 CROSS=LAST
let bw20_ghz = (bw20_hi_hz - bw20_lo_hz) / 1.0e9
echo "bw20_ghz = $&bw20_ghz"
quit
.endc
.end
