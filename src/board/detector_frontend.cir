* Atom Lithography Machine - 8-Channel IBIC Detector Front-End (v2.1, Profile=COLD_100K, Exp127)
* Native ngspice-47 macromodel deck ({Aday-COTS}; no physical lab measurement).
* Locked P91 5 keV 31P+ @ 100 K: RF=1G, CS=CP=600p (tau_s=1200 ns), Q_ION=0.055f.
* Rails: VCCA=+2.5V, VSSA=-2.5V, VCCD=+3.3V, VBIAS=-30.0V.

.temp -173.15

.param C_DET=0.5p  C_PAR=0.25p  C_F=0.25p  R_F=1G
.param C_S=600p   R_S1=2.0k    R_G1=100   R_G2=13.5k
.param R_S2=2.0k   C_P=600p    R_HYS1=1.0k R_HYS2=3.3Meg  R_TERM=49.9
.param Q_ION=0.055f  TAU_COL=1.5n  V_THR=0.00423

* Behavioral single-pole op-amp macromodels matching datasheet GBP, C_in & white e_n (native ngspice B-sources)
.subckt OPAMP_LTC6268 inp inn vcc vss out
Cin inp inn 0.45p
Rin inp inn 1T noisy=0
* White series voltage noise: 2.0 nV/rtHz (zero DC offset)
Rnw nw 0 241.43235 temp=26.85
Evn inp_int inp nw 0 1.0
Egain n1 0 inp_int inn 1e5
* GBP = 500 MHz -> dominant pole f_p = 5 kHz (R=1k, C=31.83nF)
Rp n1 n2 1k noisy=0
Cp n2 0 31.8309886n
Bbuf n_out 0 V = 0.5*(v(vcc)+v(vss)) + (0.5*(v(vcc)-v(vss))-0.1) * tanh((v(n2) - 0.5*(v(vcc)+v(vss))) / (0.5*(v(vcc)-v(vss))-0.1 + 1m))
Rout n_out out 1 noisy=0
.ends OPAMP_LTC6268

.subckt OPAMP_ADA4817 inp inn vcc vss out
Cin inp inn 1.3p
Rin inp inn 500G noisy=0
* White series voltage noise: 4.0 nV/rtHz (zero DC offset)
Rnw nw 0 965.7294 temp=26.85
Evn inp_int inp nw 0 1.0
Egain n1 0 inp_int inn 1e5
* GBP = 1.05 GHz -> dominant pole f_p = 10.5 kHz (R=1k, C=15.16nF)
Rp n1 n2 1k noisy=0
Cp n2 0 15.1576136n
Bbuf n_out 0 V = 0.5*(v(vcc)+v(vss)) + (0.5*(v(vcc)-v(vss))-0.2) * tanh((v(n2) - 0.5*(v(vcc)+v(vss))) / (0.5*(v(vcc)-v(vss))-0.2 + 1m))
Rout n_out out 1 noisy=0
.ends OPAMP_ADA4817

.subckt CMP_TLV3501 inp inn vcc gnd shdn out
* 4.5 ns comparator macromodel with rail-to-rail 0..VCCD output & smooth active-HIGH SHDN (TI SBOS321)
Braw n1 gnd V = v(vcc, gnd) * 0.5 * (1 + tanh((0.5*v(vcc, gnd) - v(shdn, gnd)) / 0.05)) * 0.5 * (1 + tanh(v(inp, inn) / 0.2m))
Rdel n1 out 100 noisy=0
Cdel out gnd 45p
.ends CMP_TLV3501

* Single IBIC Front-End Channel Subcircuit (csa_sum exposed for top-level stimulus & .noise)
.subckt IBIC_CHANNEL csa_sum hv_bias thresh_in count_hit vcca vssa vccd agnd dgnd
* Per-channel HV bias filter & pixel capacitance
Rbias hv_bias det_bias 10Meg
Cbias det_bias agnd 10n
Cdet  csa_sum agnd {C_DET + C_PAR}
* CSA stage (LTC6268): positive output when Iion extracts charge (csa_sum -> agnd)
Xcsa  agnd csa_sum vcca vssa csa_out OPAMP_LTC6268
Cf    csa_out csa_sum {C_F}
Rf    csa_out csa_sum {R_F}
* Buffered CR-RC active shaper (tau_1 = tau_2 = 1200 ns, G_stage = 136 -> G_peak = 50)
Cs    csa_out cr_out {C_S}
Rs1   cr_out  agnd   {R_S1}
Xshp  cr_out  shp_fb vcca vssa shp_gain OPAMP_ADA4817
Rg1   shp_fb  agnd   {R_G1}
Rg2   shp_gain shp_fb {R_G2}
Rs2   shp_gain shp_out {R_S2}
Cp    shp_out agnd   {C_P}
* Per-channel DAC threshold RC filter & non-latching hysteresis comparator (TLV3501, V_hys=3.0mV < V_THR)
Rdac  thresh_in thresh 1k
Cdac  thresh agnd 100n
Rhys1 shp_out cmp_inp {R_HYS1}
Rhys2 cmp_out cmp_inp {R_HYS2}
Xcmp  cmp_inp thresh vccd dgnd dgnd cmp_out CMP_TLV3501
Rterm cmp_out count_hit {R_TERM}
.ends IBIC_CHANNEL

* Board Power Supplies & Star Ground
Vcca vcca agnd DC 2.5
Vssa vssa agnd DC -2.5
Vccd vccd dgnd DC 3.3
Vbias hv_in agnd DC -30.0
Rstar agnd dgnd 1m noisy=0
Rbias_bulk hv_in hv_filt 100k
Cbias_bulk hv_filt agnd 100n
Vagnd agnd 0 DC 0

* 8-Channel Tile Instantiation (CH0..CH7) with Individual DAC Thresholds & Top-Level Ion Stimulus
* CH0 receives 5 keV 31P+ charge pulse Q_ION (csa_sum -> agnd = positive hole-collection polarity); CH1..CH7 dark
Iion0 csa_sum_0 agnd DC 0 AC 1 PULSE(0 {Q_ION/TAU_COL} 50n 0.1n 0.1n 1.4n 1m)
Vthr0 thr_raw_0 agnd DC {V_THR}
Xch0 csa_sum_0 hv_filt thr_raw_0 count_hit_0 vcca vssa vccd agnd dgnd IBIC_CHANNEL
Rfpga0 count_hit_0 dgnd 10k
Iion1 csa_sum_1 agnd DC 0
Vthr1 thr_raw_1 agnd DC {V_THR}
Xch1 csa_sum_1 hv_filt thr_raw_1 count_hit_1 vcca vssa vccd agnd dgnd IBIC_CHANNEL
Rfpga1 count_hit_1 dgnd 10k
Iion2 csa_sum_2 agnd DC 0
Vthr2 thr_raw_2 agnd DC {V_THR}
Xch2 csa_sum_2 hv_filt thr_raw_2 count_hit_2 vcca vssa vccd agnd dgnd IBIC_CHANNEL
Rfpga2 count_hit_2 dgnd 10k
Iion3 csa_sum_3 agnd DC 0
Vthr3 thr_raw_3 agnd DC {V_THR}
Xch3 csa_sum_3 hv_filt thr_raw_3 count_hit_3 vcca vssa vccd agnd dgnd IBIC_CHANNEL
Rfpga3 count_hit_3 dgnd 10k
Iion4 csa_sum_4 agnd DC 0
Vthr4 thr_raw_4 agnd DC {V_THR}
Xch4 csa_sum_4 hv_filt thr_raw_4 count_hit_4 vcca vssa vccd agnd dgnd IBIC_CHANNEL
Rfpga4 count_hit_4 dgnd 10k
Iion5 csa_sum_5 agnd DC 0
Vthr5 thr_raw_5 agnd DC {V_THR}
Xch5 csa_sum_5 hv_filt thr_raw_5 count_hit_5 vcca vssa vccd agnd dgnd IBIC_CHANNEL
Rfpga5 count_hit_5 dgnd 10k
Iion6 csa_sum_6 agnd DC 0
Vthr6 thr_raw_6 agnd DC {V_THR}
Xch6 csa_sum_6 hv_filt thr_raw_6 count_hit_6 vcca vssa vccd agnd dgnd IBIC_CHANNEL
Rfpga6 count_hit_6 dgnd 10k
Iion7 csa_sum_7 agnd DC 0
Vthr7 thr_raw_7 agnd DC {V_THR}
Xch7 csa_sum_7 hv_filt thr_raw_7 count_hit_7 vcca vssa vccd agnd dgnd IBIC_CHANNEL
Rfpga7 count_hit_7 dgnd 10k

* Native ngspice-47 Batch Analyses (AC, TRAN, NOISE)
.control
set noaskquit
ac dec 100 100 100Meg
meas ac z_peak_ohm MAX vm(Xch0.shp_out)
tran 5n 8.0u
meas tran csa_peak_v MAX v(Xch0.csa_out)
meas tran shp_peak_v MAX v(Xch0.shp_out)
meas tran hit0_init_v FIND v(count_hit_0) AT=10n
meas tran hit0_max_v MAX v(count_hit_0)
meas tran hit0_end_v FIND v(count_hit_0) AT=8.0u
meas tran hit1_max_v MAX v(count_hit_1)
meas tran hit7_max_v MAX v(count_hit_7)
noise v(Xch0.shp_out) Iion0 dec 50 1k 50Meg
setplot noise2
let shp_onoise_rms_v = onoise_total
print shp_onoise_rms_v
quit 0
.endc
.end
